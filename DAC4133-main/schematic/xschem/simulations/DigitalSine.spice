** sch_path: /home/designer/shared/libs/IHP__DAC4133/DAC4133-main/schematic/xschem/DigitalSine.sch
.subckt DigitalSine VPWR VGND rst sine_out[17] sine_out[16] sine_out[15] sine_out[14] sine_out[13] sine_out[12] sine_out[11]
+ sine_out[10] sine_out[9] sine_out[8] sine_out[7] sine_out[6] sine_out[5] sine_out[4] sine_out[3] sine_out[2] sine_out[1] sine_out[0] clk signB
+ sign

**** begin user architecture code

.include ../../../netlist/DigitalSine.spice

**** end user architecture code
.ends
