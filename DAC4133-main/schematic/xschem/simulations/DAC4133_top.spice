** sch_path: /home/designer/shared/libs/IHP__DAC4133/DAC4133-main/schematic/xschem/DAC4133_top.sch
.subckt DAC4133_top AVDD IREF VBIAS_CAP DVDD AVSS EN_AN RST CLK CC_P CC_N
*.PININFO AVDD:B IREF:B VBIAS_CAP:B DVDD:B AVSS:B EN_AN:B RST:B CLK:B CC_P:B CC_N:B
x1 AVDD AVSS EN_AN DATA[17] DATA[16] DATA[15] DATA[14] DATA[13] DATA[12] DATA[11] DATA[10] DATA[9] DATA[8] DATA[7] DATA[6] DATA[5]
+ DATA[4] DATA[3] DATA[2] DATA[1] DATA[0] IREF sign_dig signb_dig CC_P CC_N VBIAS_CAP DAC4133_dac_top
x2 DVDD AVSS RST DATA[17] DATA[16] DATA[15] DATA[14] DATA[13] DATA[12] DATA[11] DATA[10] DATA[9] DATA[8] DATA[7] DATA[6] DATA[5]
+ DATA[4] DATA[3] DATA[2] DATA[1] DATA[0] CLK signb_dig sign_dig DAC4133_digital_top
.ends

* expanding   symbol:  DAC4133_dac_top.sym # of pins=10
** sym_path: /home/designer/shared/libs/IHP__DAC4133/DAC4133-main/schematic/xschem/DAC4133_dac_top.sym
** sch_path: /home/designer/shared/libs/IHP__DAC4133/DAC4133-main/schematic/xschem/DAC4133_dac_top.sch
.subckt DAC4133_dac_top AVDD AVSS i_en DATA[17] DATA[16] DATA[15] DATA[14] DATA[13] DATA[12] DATA[11] DATA[10] DATA[9] DATA[8]
+ DATA[7] DATA[6] DATA[5] DATA[4] DATA[3] DATA[2] DATA[1] DATA[0] IREF i_sign i_signb CC_P CC_N VBIAS
*.PININFO AVDD:B AVSS:B i_en:B DATA[17:0]:B IREF:B i_sign:B CC_P:B CC_N:B i_signb:B VBIAS:B
x1 AVDD CC_P i_en CC_N AVSS IREF i_sign VBIAS i_signb ISUM en_bb DAC4133_output_ctrl_sw
x2 AVDD AVSS en_bb DATA[17] DATA[16] DATA[15] DATA[14] DATA[13] DATA[12] DATA[11] DATA[10] DATA[9] DATA[8] DATA[7] DATA[6] DATA[5]
+ DATA[4] DATA[3] DATA[2] DATA[1] DATA[0] VBIAS ISUM DAC4133_dac_bits
DD1 AVSS VBIAS dantenna l=1u w=1u
DD2 AVSS DATA[0] dantenna l=1u w=1u
.ends

* expanding   symbol:  DAC4133_digital_top.sym # of pins=7
** sym_path: /home/designer/shared/libs/IHP__DAC4133/DAC4133-main/schematic/xschem/DAC4133_digital_top.sym
** sch_path: /home/designer/shared/libs/IHP__DAC4133/DAC4133-main/schematic/xschem/DAC4133_digital_top.sch
.subckt DAC4133_digital_top DVDD DVSS rst DATA[17] DATA[16] DATA[15] DATA[14] DATA[13] DATA[12] DATA[11] DATA[10] DATA[9] DATA[8]
+ DATA[7] DATA[6] DATA[5] DATA[4] DATA[3] DATA[2] DATA[1] DATA[0] clk o_signB o_sign
*.PININFO DVDD:B DVSS:B rst:B DATA[17:0]:B clk:B o_sign:B o_signB:B
x1 DVDD DVSS rst DATA[17] DATA[16] DATA[15] DATA[14] DATA[13] DATA[12] DATA[11] DATA[10] DATA[9] DATA[8] DATA[7] DATA[6] DATA[5]
+ DATA[4] DATA[3] DATA[2] DATA[1] DATA[0] clk o_signB o_sign DigitalSine
.ends

* expanding   symbol:  DAC4133_output_ctrl_sw.sym # of pins=11
** sym_path: /home/designer/shared/libs/IHP__DAC4133/DAC4133-main/schematic/xschem/DAC4133_output_ctrl_sw.sym
** sch_path: /home/designer/shared/libs/IHP__DAC4133/DAC4133-main/schematic/xschem/DAC4133_output_ctrl_sw.sch
.subckt DAC4133_output_ctrl_sw AVDD CC_P i_en CC_N AVSS IREF i_sign IBIAS i_signb ISUM en_bb
*.PININFO AVDD:B AVSS:B i_en:B i_sign:B i_signb:B ISUM:B CC_P:B CC_N:B IREF:B IBIAS:B en_bb:B
x9 x_sign x_signb ISUM AVSS CC_P CC_N DAC4133_dsw
x1 i_en en_b AVDD AVSS DAC4133_inv
x2 en_b en_bb AVDD AVSS DAC4133_inv
x4 AVDD AVSS en_bb en_b IREF IBIAS DAC4133_tgate
x3 AVDD AVSS i_signb i_sign x_sign x_signb DAC4133_non_overlap
.ends

* expanding   symbol:  DAC4133_dac_bits.sym # of pins=6
** sym_path: /home/designer/shared/libs/IHP__DAC4133/DAC4133-main/schematic/xschem/DAC4133_dac_bits.sym
** sch_path: /home/designer/shared/libs/IHP__DAC4133/DAC4133-main/schematic/xschem/DAC4133_dac_bits.sch
.subckt DAC4133_dac_bits AVDD AVSS en_bb DATA[17] DATA[16] DATA[15] DATA[14] DATA[13] DATA[12] DATA[11] DATA[10] DATA[9] DATA[8]
+ DATA[7] DATA[6] DATA[5] DATA[4] DATA[3] DATA[2] DATA[1] DATA[0] VBIAS ISUM
*.PININFO AVDD:B AVSS:B en_bb:B DATA[17:0]:B VBIAS:B ISUM:B
xb0 AVDD AVSS VBIAS en_bb DATA[0] ISUM DAC4133_dac_unit
xb1[1] AVDD AVSS VBIAS en_bb DATA[1] ISUM DAC4133_dac_unit
xb1[0] AVDD AVSS VBIAS en_bb DATA[1] ISUM DAC4133_dac_unit
xb2[3] AVDD AVSS VBIAS en_bb DATA[2] ISUM DAC4133_dac_unit
xb2[2] AVDD AVSS VBIAS en_bb DATA[2] ISUM DAC4133_dac_unit
xb2[1] AVDD AVSS VBIAS en_bb DATA[2] ISUM DAC4133_dac_unit
xb2[0] AVDD AVSS VBIAS en_bb DATA[2] ISUM DAC4133_dac_unit
xb3[7] AVDD AVSS VBIAS en_bb DATA[3] ISUM DAC4133_dac_unit
xb3[6] AVDD AVSS VBIAS en_bb DATA[3] ISUM DAC4133_dac_unit
xb3[5] AVDD AVSS VBIAS en_bb DATA[3] ISUM DAC4133_dac_unit
xb3[4] AVDD AVSS VBIAS en_bb DATA[3] ISUM DAC4133_dac_unit
xb3[3] AVDD AVSS VBIAS en_bb DATA[3] ISUM DAC4133_dac_unit
xb3[2] AVDD AVSS VBIAS en_bb DATA[3] ISUM DAC4133_dac_unit
xb3[1] AVDD AVSS VBIAS en_bb DATA[3] ISUM DAC4133_dac_unit
xb3[0] AVDD AVSS VBIAS en_bb DATA[3] ISUM DAC4133_dac_unit
xb4[7] AVDD AVSS VBIAS en_bb DATA[4] ISUM DAC4133_dac_unit
xb4[6] AVDD AVSS VBIAS en_bb DATA[4] ISUM DAC4133_dac_unit
xb4[5] AVDD AVSS VBIAS en_bb DATA[4] ISUM DAC4133_dac_unit
xb4[4] AVDD AVSS VBIAS en_bb DATA[4] ISUM DAC4133_dac_unit
xb4[3] AVDD AVSS VBIAS en_bb DATA[4] ISUM DAC4133_dac_unit
xb4[2] AVDD AVSS VBIAS en_bb DATA[4] ISUM DAC4133_dac_unit
xb4[1] AVDD AVSS VBIAS en_bb DATA[4] ISUM DAC4133_dac_unit
xb4[0] AVDD AVSS VBIAS en_bb DATA[4] ISUM DAC4133_dac_unit
xb5[7] AVDD AVSS VBIAS en_bb DATA[5] ISUM DAC4133_dac_unit
xb5[6] AVDD AVSS VBIAS en_bb DATA[5] ISUM DAC4133_dac_unit
xb5[5] AVDD AVSS VBIAS en_bb DATA[5] ISUM DAC4133_dac_unit
xb5[4] AVDD AVSS VBIAS en_bb DATA[5] ISUM DAC4133_dac_unit
xb5[3] AVDD AVSS VBIAS en_bb DATA[5] ISUM DAC4133_dac_unit
xb5[2] AVDD AVSS VBIAS en_bb DATA[5] ISUM DAC4133_dac_unit
xb5[1] AVDD AVSS VBIAS en_bb DATA[5] ISUM DAC4133_dac_unit
xb5[0] AVDD AVSS VBIAS en_bb DATA[5] ISUM DAC4133_dac_unit
xb6[7] AVDD AVSS VBIAS en_bb DATA[6] ISUM DAC4133_dac_unit
xb6[6] AVDD AVSS VBIAS en_bb DATA[6] ISUM DAC4133_dac_unit
xb6[5] AVDD AVSS VBIAS en_bb DATA[6] ISUM DAC4133_dac_unit
xb6[4] AVDD AVSS VBIAS en_bb DATA[6] ISUM DAC4133_dac_unit
xb6[3] AVDD AVSS VBIAS en_bb DATA[6] ISUM DAC4133_dac_unit
xb6[2] AVDD AVSS VBIAS en_bb DATA[6] ISUM DAC4133_dac_unit
xb6[1] AVDD AVSS VBIAS en_bb DATA[6] ISUM DAC4133_dac_unit
xb6[0] AVDD AVSS VBIAS en_bb DATA[6] ISUM DAC4133_dac_unit
xb7[7] AVDD AVSS VBIAS en_bb DATA[7] ISUM DAC4133_dac_unit
xb7[6] AVDD AVSS VBIAS en_bb DATA[7] ISUM DAC4133_dac_unit
xb7[5] AVDD AVSS VBIAS en_bb DATA[7] ISUM DAC4133_dac_unit
xb7[4] AVDD AVSS VBIAS en_bb DATA[7] ISUM DAC4133_dac_unit
xb7[3] AVDD AVSS VBIAS en_bb DATA[7] ISUM DAC4133_dac_unit
xb7[2] AVDD AVSS VBIAS en_bb DATA[7] ISUM DAC4133_dac_unit
xb7[1] AVDD AVSS VBIAS en_bb DATA[7] ISUM DAC4133_dac_unit
xb7[0] AVDD AVSS VBIAS en_bb DATA[7] ISUM DAC4133_dac_unit
xb8[7] AVDD AVSS VBIAS en_bb DATA[8] ISUM DAC4133_dac_unit
xb8[6] AVDD AVSS VBIAS en_bb DATA[8] ISUM DAC4133_dac_unit
xb8[5] AVDD AVSS VBIAS en_bb DATA[8] ISUM DAC4133_dac_unit
xb8[4] AVDD AVSS VBIAS en_bb DATA[8] ISUM DAC4133_dac_unit
xb8[3] AVDD AVSS VBIAS en_bb DATA[8] ISUM DAC4133_dac_unit
xb8[2] AVDD AVSS VBIAS en_bb DATA[8] ISUM DAC4133_dac_unit
xb8[1] AVDD AVSS VBIAS en_bb DATA[8] ISUM DAC4133_dac_unit
xb8[0] AVDD AVSS VBIAS en_bb DATA[8] ISUM DAC4133_dac_unit
xb9[7] AVDD AVSS VBIAS en_bb DATA[9] ISUM DAC4133_dac_unit
xb9[6] AVDD AVSS VBIAS en_bb DATA[9] ISUM DAC4133_dac_unit
xb9[5] AVDD AVSS VBIAS en_bb DATA[9] ISUM DAC4133_dac_unit
xb9[4] AVDD AVSS VBIAS en_bb DATA[9] ISUM DAC4133_dac_unit
xb9[3] AVDD AVSS VBIAS en_bb DATA[9] ISUM DAC4133_dac_unit
xb9[2] AVDD AVSS VBIAS en_bb DATA[9] ISUM DAC4133_dac_unit
xb9[1] AVDD AVSS VBIAS en_bb DATA[9] ISUM DAC4133_dac_unit
xb9[0] AVDD AVSS VBIAS en_bb DATA[9] ISUM DAC4133_dac_unit
xb10[7] AVDD AVSS VBIAS en_bb DATA[10] ISUM DAC4133_dac_unit
xb10[6] AVDD AVSS VBIAS en_bb DATA[10] ISUM DAC4133_dac_unit
xb10[5] AVDD AVSS VBIAS en_bb DATA[10] ISUM DAC4133_dac_unit
xb10[4] AVDD AVSS VBIAS en_bb DATA[10] ISUM DAC4133_dac_unit
xb10[3] AVDD AVSS VBIAS en_bb DATA[10] ISUM DAC4133_dac_unit
xb10[2] AVDD AVSS VBIAS en_bb DATA[10] ISUM DAC4133_dac_unit
xb10[1] AVDD AVSS VBIAS en_bb DATA[10] ISUM DAC4133_dac_unit
xb10[0] AVDD AVSS VBIAS en_bb DATA[10] ISUM DAC4133_dac_unit
xb11[7] AVDD AVSS VBIAS en_bb DATA[11] ISUM DAC4133_dac_unit
xb11[6] AVDD AVSS VBIAS en_bb DATA[11] ISUM DAC4133_dac_unit
xb11[5] AVDD AVSS VBIAS en_bb DATA[11] ISUM DAC4133_dac_unit
xb11[4] AVDD AVSS VBIAS en_bb DATA[11] ISUM DAC4133_dac_unit
xb11[3] AVDD AVSS VBIAS en_bb DATA[11] ISUM DAC4133_dac_unit
xb11[2] AVDD AVSS VBIAS en_bb DATA[11] ISUM DAC4133_dac_unit
xb11[1] AVDD AVSS VBIAS en_bb DATA[11] ISUM DAC4133_dac_unit
xb11[0] AVDD AVSS VBIAS en_bb DATA[11] ISUM DAC4133_dac_unit
xb12[7] AVDD AVSS VBIAS en_bb DATA[12] ISUM DAC4133_dac_unit
xb12[6] AVDD AVSS VBIAS en_bb DATA[12] ISUM DAC4133_dac_unit
xb12[5] AVDD AVSS VBIAS en_bb DATA[12] ISUM DAC4133_dac_unit
xb12[4] AVDD AVSS VBIAS en_bb DATA[12] ISUM DAC4133_dac_unit
xb12[3] AVDD AVSS VBIAS en_bb DATA[12] ISUM DAC4133_dac_unit
xb12[2] AVDD AVSS VBIAS en_bb DATA[12] ISUM DAC4133_dac_unit
xb12[1] AVDD AVSS VBIAS en_bb DATA[12] ISUM DAC4133_dac_unit
xb12[0] AVDD AVSS VBIAS en_bb DATA[12] ISUM DAC4133_dac_unit
xb13[7] AVDD AVSS VBIAS en_bb DATA[13] ISUM DAC4133_dac_unit
xb13[6] AVDD AVSS VBIAS en_bb DATA[13] ISUM DAC4133_dac_unit
xb13[5] AVDD AVSS VBIAS en_bb DATA[13] ISUM DAC4133_dac_unit
xb13[4] AVDD AVSS VBIAS en_bb DATA[13] ISUM DAC4133_dac_unit
xb13[3] AVDD AVSS VBIAS en_bb DATA[13] ISUM DAC4133_dac_unit
xb13[2] AVDD AVSS VBIAS en_bb DATA[13] ISUM DAC4133_dac_unit
xb13[1] AVDD AVSS VBIAS en_bb DATA[13] ISUM DAC4133_dac_unit
xb13[0] AVDD AVSS VBIAS en_bb DATA[13] ISUM DAC4133_dac_unit
xb14[7] AVDD AVSS VBIAS en_bb DATA[14] ISUM DAC4133_dac_unit
xb14[6] AVDD AVSS VBIAS en_bb DATA[14] ISUM DAC4133_dac_unit
xb14[5] AVDD AVSS VBIAS en_bb DATA[14] ISUM DAC4133_dac_unit
xb14[4] AVDD AVSS VBIAS en_bb DATA[14] ISUM DAC4133_dac_unit
xb14[3] AVDD AVSS VBIAS en_bb DATA[14] ISUM DAC4133_dac_unit
xb14[2] AVDD AVSS VBIAS en_bb DATA[14] ISUM DAC4133_dac_unit
xb14[1] AVDD AVSS VBIAS en_bb DATA[14] ISUM DAC4133_dac_unit
xb14[0] AVDD AVSS VBIAS en_bb DATA[14] ISUM DAC4133_dac_unit
xb15[7] AVDD AVSS VBIAS en_bb DATA[15] ISUM DAC4133_dac_unit
xb15[6] AVDD AVSS VBIAS en_bb DATA[15] ISUM DAC4133_dac_unit
xb15[5] AVDD AVSS VBIAS en_bb DATA[15] ISUM DAC4133_dac_unit
xb15[4] AVDD AVSS VBIAS en_bb DATA[15] ISUM DAC4133_dac_unit
xb15[3] AVDD AVSS VBIAS en_bb DATA[15] ISUM DAC4133_dac_unit
xb15[2] AVDD AVSS VBIAS en_bb DATA[15] ISUM DAC4133_dac_unit
xb15[1] AVDD AVSS VBIAS en_bb DATA[15] ISUM DAC4133_dac_unit
xb15[0] AVDD AVSS VBIAS en_bb DATA[15] ISUM DAC4133_dac_unit
xb16[7] AVDD AVSS VBIAS en_bb DATA[16] ISUM DAC4133_dac_unit
xb16[6] AVDD AVSS VBIAS en_bb DATA[16] ISUM DAC4133_dac_unit
xb16[5] AVDD AVSS VBIAS en_bb DATA[16] ISUM DAC4133_dac_unit
xb16[4] AVDD AVSS VBIAS en_bb DATA[16] ISUM DAC4133_dac_unit
xb16[3] AVDD AVSS VBIAS en_bb DATA[16] ISUM DAC4133_dac_unit
xb16[2] AVDD AVSS VBIAS en_bb DATA[16] ISUM DAC4133_dac_unit
xb16[1] AVDD AVSS VBIAS en_bb DATA[16] ISUM DAC4133_dac_unit
xb16[0] AVDD AVSS VBIAS en_bb DATA[16] ISUM DAC4133_dac_unit
xb17[7] AVDD AVSS VBIAS en_bb DATA[17] ISUM DAC4133_dac_unit
xb17[6] AVDD AVSS VBIAS en_bb DATA[17] ISUM DAC4133_dac_unit
xb17[5] AVDD AVSS VBIAS en_bb DATA[17] ISUM DAC4133_dac_unit
xb17[4] AVDD AVSS VBIAS en_bb DATA[17] ISUM DAC4133_dac_unit
xb17[3] AVDD AVSS VBIAS en_bb DATA[17] ISUM DAC4133_dac_unit
xb17[2] AVDD AVSS VBIAS en_bb DATA[17] ISUM DAC4133_dac_unit
xb17[1] AVDD AVSS VBIAS en_bb DATA[17] ISUM DAC4133_dac_unit
xb17[0] AVDD AVSS VBIAS en_bb DATA[17] ISUM DAC4133_dac_unit
x1[7] AVDD AVSS VBIAS en_bb AVSS VBIAS DAC4133_dac_unit
x1[6] AVDD AVSS VBIAS en_bb AVSS VBIAS DAC4133_dac_unit
x1[5] AVDD AVSS VBIAS en_bb AVSS VBIAS DAC4133_dac_unit
x1[4] AVDD AVSS VBIAS en_bb AVSS VBIAS DAC4133_dac_unit
x1[3] AVDD AVSS VBIAS en_bb AVSS VBIAS DAC4133_dac_unit
x1[2] AVDD AVSS VBIAS en_bb AVSS VBIAS DAC4133_dac_unit
x1[1] AVDD AVSS VBIAS en_bb AVSS VBIAS DAC4133_dac_unit
x1[0] AVDD AVSS VBIAS en_bb AVSS VBIAS DAC4133_dac_unit
x11 AVDD AVSS DAC4133_dac_unit_DMY
x12 AVDD AVSS DAC4133_dac_unit_DMY
x13 AVDD AVSS DAC4133_dac_unit_DMY
x14 AVDD AVSS DAC4133_dac_unit_DMY
x15 AVDD AVSS DAC4133_dac_unit_DMY
x16 AVDD AVSS DAC4133_dac_unit_DMY
x17 AVDD AVSS DAC4133_dac_unit_DMY
x18 AVDD AVSS DAC4133_dac_unit_DMY
x19 AVDD AVSS DAC4133_dac_unit_DMY
x110 AVDD AVSS DAC4133_dac_unit_DMY
x111 AVDD AVSS DAC4133_dac_unit_DMY
x112 AVDD AVSS DAC4133_dac_unit_DMY
x113 AVDD AVSS DAC4133_dac_unit_DMY
x114 AVDD AVSS DAC4133_dac_unit_DMY
x115 AVDD AVSS DAC4133_dac_unit_DMY
x116 AVDD AVSS DAC4133_dac_unit_DMY
x117 AVDD AVSS DAC4133_dac_unit_DMY
x118 AVDD AVSS DAC4133_dac_unit_DMY
x119 AVDD AVSS DAC4133_dac_unit_DMY
x120 AVDD AVSS DAC4133_dac_unit_DMY
x121 AVDD AVSS DAC4133_dac_unit_DMY
x122 AVDD AVSS DAC4133_dac_unit_DMY
x123 AVDD AVSS DAC4133_dac_unit_DMY
x124 AVDD AVSS DAC4133_dac_unit_DMY
x125 AVDD AVSS DAC4133_dac_unit_DMY
x126 AVDD AVSS DAC4133_dac_unit_DMY
x127 AVDD AVSS DAC4133_dac_unit_DMY
x128 AVDD AVSS DAC4133_dac_unit_DMY
x129 AVDD AVSS DAC4133_dac_unit_DMY
x130 AVDD AVSS DAC4133_dac_unit_DMY
x131 AVDD AVSS DAC4133_dac_unit_DMY
x132 AVDD AVSS DAC4133_dac_unit_DMY
x133 AVDD AVSS DAC4133_dac_unit_DMY
x134 AVDD AVSS DAC4133_dac_unit_DMY
x135 AVDD AVSS DAC4133_dac_unit_DMY
x136 AVDD AVSS DAC4133_dac_unit_DMY
x137 AVDD AVSS DAC4133_dac_unit_DMY
x138 AVDD AVSS DAC4133_dac_unit_DMY
x139 AVDD AVSS DAC4133_dac_unit_DMY
x140 AVDD AVSS DAC4133_dac_unit_DMY
x141 AVDD AVSS DAC4133_dac_unit_DMY
x142 AVDD AVSS DAC4133_dac_unit_DMY
x143 AVDD AVSS DAC4133_dac_unit_DMY
x144 AVDD AVSS DAC4133_dac_unit_DMY
x145 AVDD AVSS DAC4133_dac_unit_DMY
x146 AVDD AVSS DAC4133_dac_unit_DMY
x147 AVDD AVSS DAC4133_dac_unit_DMY
x148 AVDD AVSS DAC4133_dac_unit_DMY
x149 AVDD AVSS DAC4133_dac_unit_DMY
x150 AVDD AVSS DAC4133_dac_unit_DMY
x151 AVDD AVSS DAC4133_dac_unit_DMY
x152 AVDD AVSS DAC4133_dac_unit_DMY
x153 AVDD AVSS DAC4133_dac_unit_DMY
x154 AVDD AVSS DAC4133_dac_unit_DMY
x155 AVDD AVSS DAC4133_dac_unit_DMY
x156 AVDD AVSS DAC4133_dac_unit_DMY
x157 AVDD AVSS DAC4133_dac_unit_DMY
.ends

* expanding   symbol:  DAC4133_dsw.sym # of pins=6
** sym_path: /home/designer/shared/libs/IHP__DAC4133/DAC4133-main/schematic/xschem/DAC4133_dsw.sym
** sch_path: /home/designer/shared/libs/IHP__DAC4133/DAC4133-main/schematic/xschem/DAC4133_dsw.sch
.subckt DAC4133_dsw SIGN SIGNB IN AVSS VOP VOM
*.PININFO SIGN:B SIGNB:B IN:B AVSS:B VOP:B VOM:B
MM1 IN SIGN VOM AVSS sg13_lv_nmos w=3u l=0.13u ng=1 m=2
MM2 VOM SIGNB AVSS AVSS sg13_lv_nmos w=3u l=0.13u ng=1 m=2
MM3 IN SIGNB VOP AVSS sg13_lv_nmos w=3u l=0.13u ng=1 m=2
MM4 VOP SIGN AVSS AVSS sg13_lv_nmos w=3u l=0.13u ng=1 m=2
.ends

* expanding   symbol:  DAC4133_inv.sym # of pins=4
** sym_path: /home/designer/shared/libs/IHP__DAC4133/DAC4133-main/schematic/xschem/DAC4133_inv.sym
** sch_path: /home/designer/shared/libs/IHP__DAC4133/DAC4133-main/schematic/xschem/DAC4133_inv.sch
.subckt DAC4133_inv A Y VDD VSS
*.PININFO Y:O A:I VDD:B VSS:B
MMN0 Y A VSS VSS sg13_lv_nmos w=740.00n l=130.00n ng=1
MMP0 Y A VDD VDD sg13_lv_pmos w=1.12u l=130.00n ng=1
.ends

* expanding   symbol:  DAC4133_tgate.sym # of pins=6
** sym_path: /home/designer/shared/libs/IHP__DAC4133/DAC4133-main/schematic/xschem/DAC4133_tgate.sym
** sch_path: /home/designer/shared/libs/IHP__DAC4133/DAC4133-main/schematic/xschem/DAC4133_tgate.sch
.subckt DAC4133_tgate AVDD AVSS EN ENB A B
*.PININFO AVDD:B AVSS:B EN:B ENB:B A:B B:B
MM1 A EN B AVSS sg13_lv_nmos w=1u l=1u ng=1 m=2
MM2 B ENB A AVDD sg13_lv_pmos w=1u l=1u ng=1 m=2
.ends

* expanding   symbol:  DAC4133_non_overlap.sym # of pins=6
** sym_path: /home/designer/shared/libs/IHP__DAC4133/DAC4133-main/schematic/xschem/DAC4133_non_overlap.sym
** sch_path: /home/designer/shared/libs/IHP__DAC4133/DAC4133-main/schematic/xschem/DAC4133_non_overlap.sch
.subckt DAC4133_non_overlap AVDD AVSS i_signb i_sign o_sign o_signb
*.PININFO AVDD:B AVSS:B i_sign:B i_signb:B o_sign:B o_signb:B
x5 AVDD AVSS i_sign xb xa DAC4133_nand
x6 xa o_sign AVDD AVSS DAC4133_inv
x3 AVDD AVSS i_signb xa xb DAC4133_nand
x1 xb o_signb AVDD AVSS DAC4133_inv
.ends

* expanding   symbol:  DAC4133_dac_unit.sym # of pins=6
** sym_path: /home/designer/shared/libs/IHP__DAC4133/DAC4133-main/schematic/xschem/DAC4133_dac_unit.sym
** sch_path: /home/designer/shared/libs/IHP__DAC4133/DAC4133-main/schematic/xschem/DAC4133_dac_unit.sch
.subckt DAC4133_dac_unit AVDD AVSS VBIAS en DATA ISUM
*.PININFO AVDD:B AVSS:B VBIAS:B en:B DATA:B ISUM:B
MM1 ISUM VBIAS VS_cm AVDD sg13_lv_pmos w=0.72u l=3u ng=1 m=4
MM2 VBIAS en AVDD AVDD sg13_lv_pmos w=0.72u l=3u ng=1 m=4
MM3 AVDD AVDD AVDD AVDD sg13_lv_pmos w=0.72u l=1.5u ng=1 m=8
x20 DATA VS_cm AVDD AVSS DAC4133_inv
.ends

* expanding   symbol:  DAC4133_dac_unit_DMY.sym # of pins=2
** sym_path: /home/designer/shared/libs/IHP__DAC4133/DAC4133-main/schematic/xschem/DAC4133_dac_unit_DMY.sym
** sch_path: /home/designer/shared/libs/IHP__DAC4133/DAC4133-main/schematic/xschem/DAC4133_dac_unit_DMY.sch
.subckt DAC4133_dac_unit_DMY AVDD AVSS
*.PININFO AVDD:B AVSS:B
MMN0 AVSS AVDD AVSS AVSS sg13_lv_nmos w=740.00n l=130.00n ng=1
MMP0 AVSS AVDD AVDD AVDD sg13_lv_pmos w=1.12u l=130.00n ng=1
MMP11 AVDD AVDD AVDD AVDD sg13_lv_pmos w=0.72u l=1.5u ng=1
MP12 AVDD AVDD AVDD AVDD sg13_lv_pmos w=0.72u l=1.5u ng=1
MP13 AVDD AVDD AVDD AVDD sg13_lv_pmos w=0.72u l=1.5u ng=1
MP14 AVDD AVDD AVDD AVDD sg13_lv_pmos w=0.72u l=1.5u ng=1
MP15 AVDD AVDD AVDD AVDD sg13_lv_pmos w=0.72u l=1.5u ng=1
MP16 AVDD AVDD AVDD AVDD sg13_lv_pmos w=0.72u l=1.5u ng=1
MP17 AVDD AVDD AVDD AVDD sg13_lv_pmos w=0.72u l=1.5u ng=1
MP18 AVDD AVDD AVDD AVDD sg13_lv_pmos w=0.72u l=1.5u ng=1
MMP51 AVDD AVDD AVDD AVDD sg13_lv_pmos w=0.72u l=3u ng=1
MP52 AVDD AVDD AVDD AVDD sg13_lv_pmos w=0.72u l=3u ng=1
MP53 AVDD AVDD AVDD AVDD sg13_lv_pmos w=0.72u l=3u ng=1
MP54 AVDD AVDD AVDD AVDD sg13_lv_pmos w=0.72u l=3u ng=1
MMP21 AVDD AVDD AVDD AVDD sg13_lv_pmos w=0.72u l=3u ng=1
MP22 AVDD AVDD AVDD AVDD sg13_lv_pmos w=0.72u l=3u ng=1
MP23 AVDD AVDD AVDD AVDD sg13_lv_pmos w=0.72u l=3u ng=1
MP24 AVDD AVDD AVDD AVDD sg13_lv_pmos w=0.72u l=3u ng=1
.ends

* expanding   symbol:  DAC4133_nand.sym # of pins=5
** sym_path: /home/designer/shared/libs/IHP__DAC4133/DAC4133-main/schematic/xschem/DAC4133_nand.sym
** sch_path: /home/designer/shared/libs/IHP__DAC4133/DAC4133-main/schematic/xschem/DAC4133_nand.sch
.subckt DAC4133_nand VDD VSS A B Y
*.PININFO Y:O A:I VDD:B VSS:B B:I
MMN0 net1 B VSS VSS sg13_lv_nmos w=1.44u l=130.00n ng=2
MMP0 Y B VDD VDD sg13_lv_pmos w=2.24u l=130.00n ng=2
MMN1 Y A net1 VSS sg13_lv_nmos w=1.44u l=130.00n ng=2
MMP1 Y A VDD VDD sg13_lv_pmos w=2.24u l=130.00n ng=2
.ends
