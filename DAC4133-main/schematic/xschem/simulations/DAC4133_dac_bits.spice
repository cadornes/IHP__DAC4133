** sch_path: /home/designer/shared/libs/IHP__DAC4133/DAC4133-main/schematic/xschem/DAC4133_dac_bits.sch
.subckt DAC4133_dac_bits AVDD AVSS en_bb DATA[17] DATA[16] DATA[15] DATA[14] DATA[13] DATA[12] DATA[11] DATA[10] DATA[9] DATA[8]
+ DATA[7] DATA[6] DATA[5] DATA[4] DATA[3] DATA[2] DATA[1] DATA[0] VBIAS ISUM
*.PININFO AVDD:B AVSS:B en_bb:B DATA[17:0]:B VBIAS:B ISUM:B
xb0 AVDD AVSS VBIAS en_bb DATA[0] ISUM DAC4133_dac_unit
xb1[1] AVDD AVSS VBIAS en_bb DATA[1] ISUM DAC4133_dac_unit
xb1[0] AVDD AVSS VBIAS en_bb DATA[1] ISUM DAC4133_dac_unit
xb2[3] AVDD AVSS VBIAS en_bb DATA[2] ISUM DAC4133_dac_unit
xb2[2] AVDD AVSS VBIAS en_bb DATA[2] ISUM DAC4133_dac_unit
xb2[1] AVDD AVSS VBIAS en_bb DATA[2] ISUM DAC4133_dac_unit
xb2[0] AVDD AVSS VBIAS en_bb DATA[2] ISUM DAC4133_dac_unit
xb3[7] AVDD AVSS VBIAS en_bb DATA[3] ISUM DAC4133_dac_unit
xb3[6] AVDD AVSS VBIAS en_bb DATA[3] ISUM DAC4133_dac_unit
xb3[5] AVDD AVSS VBIAS en_bb DATA[3] ISUM DAC4133_dac_unit
xb3[4] AVDD AVSS VBIAS en_bb DATA[3] ISUM DAC4133_dac_unit
xb3[3] AVDD AVSS VBIAS en_bb DATA[3] ISUM DAC4133_dac_unit
xb3[2] AVDD AVSS VBIAS en_bb DATA[3] ISUM DAC4133_dac_unit
xb3[1] AVDD AVSS VBIAS en_bb DATA[3] ISUM DAC4133_dac_unit
xb3[0] AVDD AVSS VBIAS en_bb DATA[3] ISUM DAC4133_dac_unit
xb4[7] AVDD AVSS VBIAS en_bb DATA[4] ISUM DAC4133_dac_unit
xb4[6] AVDD AVSS VBIAS en_bb DATA[4] ISUM DAC4133_dac_unit
xb4[5] AVDD AVSS VBIAS en_bb DATA[4] ISUM DAC4133_dac_unit
xb4[4] AVDD AVSS VBIAS en_bb DATA[4] ISUM DAC4133_dac_unit
xb4[3] AVDD AVSS VBIAS en_bb DATA[4] ISUM DAC4133_dac_unit
xb4[2] AVDD AVSS VBIAS en_bb DATA[4] ISUM DAC4133_dac_unit
xb4[1] AVDD AVSS VBIAS en_bb DATA[4] ISUM DAC4133_dac_unit
xb4[0] AVDD AVSS VBIAS en_bb DATA[4] ISUM DAC4133_dac_unit
xb5[7] AVDD AVSS VBIAS en_bb DATA[5] ISUM DAC4133_dac_unit
xb5[6] AVDD AVSS VBIAS en_bb DATA[5] ISUM DAC4133_dac_unit
xb5[5] AVDD AVSS VBIAS en_bb DATA[5] ISUM DAC4133_dac_unit
xb5[4] AVDD AVSS VBIAS en_bb DATA[5] ISUM DAC4133_dac_unit
xb5[3] AVDD AVSS VBIAS en_bb DATA[5] ISUM DAC4133_dac_unit
xb5[2] AVDD AVSS VBIAS en_bb DATA[5] ISUM DAC4133_dac_unit
xb5[1] AVDD AVSS VBIAS en_bb DATA[5] ISUM DAC4133_dac_unit
xb5[0] AVDD AVSS VBIAS en_bb DATA[5] ISUM DAC4133_dac_unit
xb6[7] AVDD AVSS VBIAS en_bb DATA[6] ISUM DAC4133_dac_unit
xb6[6] AVDD AVSS VBIAS en_bb DATA[6] ISUM DAC4133_dac_unit
xb6[5] AVDD AVSS VBIAS en_bb DATA[6] ISUM DAC4133_dac_unit
xb6[4] AVDD AVSS VBIAS en_bb DATA[6] ISUM DAC4133_dac_unit
xb6[3] AVDD AVSS VBIAS en_bb DATA[6] ISUM DAC4133_dac_unit
xb6[2] AVDD AVSS VBIAS en_bb DATA[6] ISUM DAC4133_dac_unit
xb6[1] AVDD AVSS VBIAS en_bb DATA[6] ISUM DAC4133_dac_unit
xb6[0] AVDD AVSS VBIAS en_bb DATA[6] ISUM DAC4133_dac_unit
xb7[7] AVDD AVSS VBIAS en_bb DATA[7] ISUM DAC4133_dac_unit
xb7[6] AVDD AVSS VBIAS en_bb DATA[7] ISUM DAC4133_dac_unit
xb7[5] AVDD AVSS VBIAS en_bb DATA[7] ISUM DAC4133_dac_unit
xb7[4] AVDD AVSS VBIAS en_bb DATA[7] ISUM DAC4133_dac_unit
xb7[3] AVDD AVSS VBIAS en_bb DATA[7] ISUM DAC4133_dac_unit
xb7[2] AVDD AVSS VBIAS en_bb DATA[7] ISUM DAC4133_dac_unit
xb7[1] AVDD AVSS VBIAS en_bb DATA[7] ISUM DAC4133_dac_unit
xb7[0] AVDD AVSS VBIAS en_bb DATA[7] ISUM DAC4133_dac_unit
xb8[7] AVDD AVSS VBIAS en_bb DATA[8] ISUM DAC4133_dac_unit
xb8[6] AVDD AVSS VBIAS en_bb DATA[8] ISUM DAC4133_dac_unit
xb8[5] AVDD AVSS VBIAS en_bb DATA[8] ISUM DAC4133_dac_unit
xb8[4] AVDD AVSS VBIAS en_bb DATA[8] ISUM DAC4133_dac_unit
xb8[3] AVDD AVSS VBIAS en_bb DATA[8] ISUM DAC4133_dac_unit
xb8[2] AVDD AVSS VBIAS en_bb DATA[8] ISUM DAC4133_dac_unit
xb8[1] AVDD AVSS VBIAS en_bb DATA[8] ISUM DAC4133_dac_unit
xb8[0] AVDD AVSS VBIAS en_bb DATA[8] ISUM DAC4133_dac_unit
xb9[7] AVDD AVSS VBIAS en_bb DATA[9] ISUM DAC4133_dac_unit
xb9[6] AVDD AVSS VBIAS en_bb DATA[9] ISUM DAC4133_dac_unit
xb9[5] AVDD AVSS VBIAS en_bb DATA[9] ISUM DAC4133_dac_unit
xb9[4] AVDD AVSS VBIAS en_bb DATA[9] ISUM DAC4133_dac_unit
xb9[3] AVDD AVSS VBIAS en_bb DATA[9] ISUM DAC4133_dac_unit
xb9[2] AVDD AVSS VBIAS en_bb DATA[9] ISUM DAC4133_dac_unit
xb9[1] AVDD AVSS VBIAS en_bb DATA[9] ISUM DAC4133_dac_unit
xb9[0] AVDD AVSS VBIAS en_bb DATA[9] ISUM DAC4133_dac_unit
xb10[7] AVDD AVSS VBIAS en_bb DATA[10] ISUM DAC4133_dac_unit
xb10[6] AVDD AVSS VBIAS en_bb DATA[10] ISUM DAC4133_dac_unit
xb10[5] AVDD AVSS VBIAS en_bb DATA[10] ISUM DAC4133_dac_unit
xb10[4] AVDD AVSS VBIAS en_bb DATA[10] ISUM DAC4133_dac_unit
xb10[3] AVDD AVSS VBIAS en_bb DATA[10] ISUM DAC4133_dac_unit
xb10[2] AVDD AVSS VBIAS en_bb DATA[10] ISUM DAC4133_dac_unit
xb10[1] AVDD AVSS VBIAS en_bb DATA[10] ISUM DAC4133_dac_unit
xb10[0] AVDD AVSS VBIAS en_bb DATA[10] ISUM DAC4133_dac_unit
xb11[7] AVDD AVSS VBIAS en_bb DATA[11] ISUM DAC4133_dac_unit
xb11[6] AVDD AVSS VBIAS en_bb DATA[11] ISUM DAC4133_dac_unit
xb11[5] AVDD AVSS VBIAS en_bb DATA[11] ISUM DAC4133_dac_unit
xb11[4] AVDD AVSS VBIAS en_bb DATA[11] ISUM DAC4133_dac_unit
xb11[3] AVDD AVSS VBIAS en_bb DATA[11] ISUM DAC4133_dac_unit
xb11[2] AVDD AVSS VBIAS en_bb DATA[11] ISUM DAC4133_dac_unit
xb11[1] AVDD AVSS VBIAS en_bb DATA[11] ISUM DAC4133_dac_unit
xb11[0] AVDD AVSS VBIAS en_bb DATA[11] ISUM DAC4133_dac_unit
xb12[7] AVDD AVSS VBIAS en_bb DATA[12] ISUM DAC4133_dac_unit
xb12[6] AVDD AVSS VBIAS en_bb DATA[12] ISUM DAC4133_dac_unit
xb12[5] AVDD AVSS VBIAS en_bb DATA[12] ISUM DAC4133_dac_unit
xb12[4] AVDD AVSS VBIAS en_bb DATA[12] ISUM DAC4133_dac_unit
xb12[3] AVDD AVSS VBIAS en_bb DATA[12] ISUM DAC4133_dac_unit
xb12[2] AVDD AVSS VBIAS en_bb DATA[12] ISUM DAC4133_dac_unit
xb12[1] AVDD AVSS VBIAS en_bb DATA[12] ISUM DAC4133_dac_unit
xb12[0] AVDD AVSS VBIAS en_bb DATA[12] ISUM DAC4133_dac_unit
xb13[7] AVDD AVSS VBIAS en_bb DATA[13] ISUM DAC4133_dac_unit
xb13[6] AVDD AVSS VBIAS en_bb DATA[13] ISUM DAC4133_dac_unit
xb13[5] AVDD AVSS VBIAS en_bb DATA[13] ISUM DAC4133_dac_unit
xb13[4] AVDD AVSS VBIAS en_bb DATA[13] ISUM DAC4133_dac_unit
xb13[3] AVDD AVSS VBIAS en_bb DATA[13] ISUM DAC4133_dac_unit
xb13[2] AVDD AVSS VBIAS en_bb DATA[13] ISUM DAC4133_dac_unit
xb13[1] AVDD AVSS VBIAS en_bb DATA[13] ISUM DAC4133_dac_unit
xb13[0] AVDD AVSS VBIAS en_bb DATA[13] ISUM DAC4133_dac_unit
xb14[7] AVDD AVSS VBIAS en_bb DATA[14] ISUM DAC4133_dac_unit
xb14[6] AVDD AVSS VBIAS en_bb DATA[14] ISUM DAC4133_dac_unit
xb14[5] AVDD AVSS VBIAS en_bb DATA[14] ISUM DAC4133_dac_unit
xb14[4] AVDD AVSS VBIAS en_bb DATA[14] ISUM DAC4133_dac_unit
xb14[3] AVDD AVSS VBIAS en_bb DATA[14] ISUM DAC4133_dac_unit
xb14[2] AVDD AVSS VBIAS en_bb DATA[14] ISUM DAC4133_dac_unit
xb14[1] AVDD AVSS VBIAS en_bb DATA[14] ISUM DAC4133_dac_unit
xb14[0] AVDD AVSS VBIAS en_bb DATA[14] ISUM DAC4133_dac_unit
xb15[7] AVDD AVSS VBIAS en_bb DATA[15] ISUM DAC4133_dac_unit
xb15[6] AVDD AVSS VBIAS en_bb DATA[15] ISUM DAC4133_dac_unit
xb15[5] AVDD AVSS VBIAS en_bb DATA[15] ISUM DAC4133_dac_unit
xb15[4] AVDD AVSS VBIAS en_bb DATA[15] ISUM DAC4133_dac_unit
xb15[3] AVDD AVSS VBIAS en_bb DATA[15] ISUM DAC4133_dac_unit
xb15[2] AVDD AVSS VBIAS en_bb DATA[15] ISUM DAC4133_dac_unit
xb15[1] AVDD AVSS VBIAS en_bb DATA[15] ISUM DAC4133_dac_unit
xb15[0] AVDD AVSS VBIAS en_bb DATA[15] ISUM DAC4133_dac_unit
xb16[7] AVDD AVSS VBIAS en_bb DATA[16] ISUM DAC4133_dac_unit
xb16[6] AVDD AVSS VBIAS en_bb DATA[16] ISUM DAC4133_dac_unit
xb16[5] AVDD AVSS VBIAS en_bb DATA[16] ISUM DAC4133_dac_unit
xb16[4] AVDD AVSS VBIAS en_bb DATA[16] ISUM DAC4133_dac_unit
xb16[3] AVDD AVSS VBIAS en_bb DATA[16] ISUM DAC4133_dac_unit
xb16[2] AVDD AVSS VBIAS en_bb DATA[16] ISUM DAC4133_dac_unit
xb16[1] AVDD AVSS VBIAS en_bb DATA[16] ISUM DAC4133_dac_unit
xb16[0] AVDD AVSS VBIAS en_bb DATA[16] ISUM DAC4133_dac_unit
xb17[7] AVDD AVSS VBIAS en_bb DATA[17] ISUM DAC4133_dac_unit
xb17[6] AVDD AVSS VBIAS en_bb DATA[17] ISUM DAC4133_dac_unit
xb17[5] AVDD AVSS VBIAS en_bb DATA[17] ISUM DAC4133_dac_unit
xb17[4] AVDD AVSS VBIAS en_bb DATA[17] ISUM DAC4133_dac_unit
xb17[3] AVDD AVSS VBIAS en_bb DATA[17] ISUM DAC4133_dac_unit
xb17[2] AVDD AVSS VBIAS en_bb DATA[17] ISUM DAC4133_dac_unit
xb17[1] AVDD AVSS VBIAS en_bb DATA[17] ISUM DAC4133_dac_unit
xb17[0] AVDD AVSS VBIAS en_bb DATA[17] ISUM DAC4133_dac_unit
x1[7] AVDD AVSS VBIAS en_bb net1 VBIAS DAC4133_dac_unit
x1[6] AVDD AVSS VBIAS en_bb net1 VBIAS DAC4133_dac_unit
x1[5] AVDD AVSS VBIAS en_bb net1 VBIAS DAC4133_dac_unit
x1[4] AVDD AVSS VBIAS en_bb net1 VBIAS DAC4133_dac_unit
x1[3] AVDD AVSS VBIAS en_bb net1 VBIAS DAC4133_dac_unit
x1[2] AVDD AVSS VBIAS en_bb net1 VBIAS DAC4133_dac_unit
x1[1] AVDD AVSS VBIAS en_bb net1 VBIAS DAC4133_dac_unit
x1[0] AVDD AVSS VBIAS en_bb net1 VBIAS DAC4133_dac_unit
x11 AVDD AVSS DAC4133_dac_unit_DMY
x12 AVDD AVSS DAC4133_dac_unit_DMY
x13 AVDD AVSS DAC4133_dac_unit_DMY
x14 AVDD AVSS DAC4133_dac_unit_DMY
x15 AVDD AVSS DAC4133_dac_unit_DMY
x16 AVDD AVSS DAC4133_dac_unit_DMY
x17 AVDD AVSS DAC4133_dac_unit_DMY
x18 AVDD AVSS DAC4133_dac_unit_DMY
x19 AVDD AVSS DAC4133_dac_unit_DMY
x110 AVDD AVSS DAC4133_dac_unit_DMY
x111 AVDD AVSS DAC4133_dac_unit_DMY
x112 AVDD AVSS DAC4133_dac_unit_DMY
x113 AVDD AVSS DAC4133_dac_unit_DMY
x114 AVDD AVSS DAC4133_dac_unit_DMY
x115 AVDD AVSS DAC4133_dac_unit_DMY
x116 AVDD AVSS DAC4133_dac_unit_DMY
x117 AVDD AVSS DAC4133_dac_unit_DMY
x118 AVDD AVSS DAC4133_dac_unit_DMY
x119 AVDD AVSS DAC4133_dac_unit_DMY
x120 AVDD AVSS DAC4133_dac_unit_DMY
x121 AVDD AVSS DAC4133_dac_unit_DMY
x122 AVDD AVSS DAC4133_dac_unit_DMY
x123 AVDD AVSS DAC4133_dac_unit_DMY
x124 AVDD AVSS DAC4133_dac_unit_DMY
x125 AVDD AVSS DAC4133_dac_unit_DMY
x126 AVDD AVSS DAC4133_dac_unit_DMY
x127 AVDD AVSS DAC4133_dac_unit_DMY
x128 AVDD AVSS DAC4133_dac_unit_DMY
x129 AVDD AVSS DAC4133_dac_unit_DMY
x130 AVDD AVSS DAC4133_dac_unit_DMY
x131 AVDD AVSS DAC4133_dac_unit_DMY
x132 AVDD AVSS DAC4133_dac_unit_DMY
x133 AVDD AVSS DAC4133_dac_unit_DMY
x134 AVDD AVSS DAC4133_dac_unit_DMY
x135 AVDD AVSS DAC4133_dac_unit_DMY
x136 AVDD AVSS DAC4133_dac_unit_DMY
x137 AVDD AVSS DAC4133_dac_unit_DMY
x138 AVDD AVSS DAC4133_dac_unit_DMY
x139 AVDD AVSS DAC4133_dac_unit_DMY
x140 AVDD AVSS DAC4133_dac_unit_DMY
x141 AVDD AVSS DAC4133_dac_unit_DMY
x142 AVDD AVSS DAC4133_dac_unit_DMY
x143 AVDD AVSS DAC4133_dac_unit_DMY
x144 AVDD AVSS DAC4133_dac_unit_DMY
x145 AVDD AVSS DAC4133_dac_unit_DMY
x146 AVDD AVSS DAC4133_dac_unit_DMY
x147 AVDD AVSS DAC4133_dac_unit_DMY
x148 AVDD AVSS DAC4133_dac_unit_DMY
x149 AVDD AVSS DAC4133_dac_unit_DMY
x150 AVDD AVSS DAC4133_dac_unit_DMY
x151 AVDD AVSS DAC4133_dac_unit_DMY
x152 AVDD AVSS DAC4133_dac_unit_DMY
x153 AVDD AVSS DAC4133_dac_unit_DMY
x154 AVDD AVSS DAC4133_dac_unit_DMY
x155 AVDD AVSS DAC4133_dac_unit_DMY
x156 AVDD AVSS DAC4133_dac_unit_DMY
x157 AVDD AVSS DAC4133_dac_unit_DMY
RR1 net1 AVSS 24.86 $SUB=sub! $[rsil] w=0.5e-6 l=0.5e-6
.ends

* expanding   symbol:  DAC4133_dac_unit.sym # of pins=6
** sym_path: /home/designer/shared/libs/IHP__DAC4133/DAC4133-main/schematic/xschem/DAC4133_dac_unit.sym
** sch_path: /home/designer/shared/libs/IHP__DAC4133/DAC4133-main/schematic/xschem/DAC4133_dac_unit.sch
.subckt DAC4133_dac_unit AVDD AVSS VBIAS en DATA ISUM
*.PININFO AVDD:B AVSS:B VBIAS:B en:B DATA:B ISUM:B
MM1 ISUM VBIAS VS_cm AVDD sg13_lv_pmos w=0.72u l=3u ng=1 m=4
MM2 VBIAS en AVDD AVDD sg13_lv_pmos w=0.72u l=3u ng=1 m=4
MM3 AVDD AVDD AVDD AVDD sg13_lv_pmos w=0.72u l=1.5u ng=1 m=8
x20 DATA VS_cm AVDD AVSS DAC4133_inv
.ends

* expanding   symbol:  DAC4133_dac_unit_DMY.sym # of pins=2
** sym_path: /home/designer/shared/libs/IHP__DAC4133/DAC4133-main/schematic/xschem/DAC4133_dac_unit_DMY.sym
** sch_path: /home/designer/shared/libs/IHP__DAC4133/DAC4133-main/schematic/xschem/DAC4133_dac_unit_DMY.sch
.subckt DAC4133_dac_unit_DMY AVDD AVSS
*.PININFO AVDD:B AVSS:B
MMN0 AVSS AVDD AVSS AVSS sg13_lv_nmos w=740.00n l=130.00n ng=1
MMP0 AVSS AVDD AVDD AVDD sg13_lv_pmos w=1.12u l=130.00n ng=1
MMP11 AVDD AVDD AVDD AVDD sg13_lv_pmos w=0.72u l=1.5u ng=1
MP12 AVDD AVDD AVDD AVDD sg13_lv_pmos w=0.72u l=1.5u ng=1
MP13 AVDD AVDD AVDD AVDD sg13_lv_pmos w=0.72u l=1.5u ng=1
MP14 AVDD AVDD AVDD AVDD sg13_lv_pmos w=0.72u l=1.5u ng=1
MP15 AVDD AVDD AVDD AVDD sg13_lv_pmos w=0.72u l=1.5u ng=1
MP16 AVDD AVDD AVDD AVDD sg13_lv_pmos w=0.72u l=1.5u ng=1
MP17 AVDD AVDD AVDD AVDD sg13_lv_pmos w=0.72u l=1.5u ng=1
MP18 AVDD AVDD AVDD AVDD sg13_lv_pmos w=0.72u l=1.5u ng=1
MMP51 AVDD AVDD AVDD AVDD sg13_lv_pmos w=0.72u l=3u ng=1
MP52 AVDD AVDD AVDD AVDD sg13_lv_pmos w=0.72u l=3u ng=1
MP53 AVDD AVDD AVDD AVDD sg13_lv_pmos w=0.72u l=3u ng=1
MP54 AVDD AVDD AVDD AVDD sg13_lv_pmos w=0.72u l=3u ng=1
MMP21 AVDD AVDD AVDD AVDD sg13_lv_pmos w=0.72u l=3u ng=1
MP22 AVDD AVDD AVDD AVDD sg13_lv_pmos w=0.72u l=3u ng=1
MP23 AVDD AVDD AVDD AVDD sg13_lv_pmos w=0.72u l=3u ng=1
MP24 AVDD AVDD AVDD AVDD sg13_lv_pmos w=0.72u l=3u ng=1
.ends

* expanding   symbol:  DAC4133_inv.sym # of pins=4
** sym_path: /home/designer/shared/libs/IHP__DAC4133/DAC4133-main/schematic/xschem/DAC4133_inv.sym
** sch_path: /home/designer/shared/libs/IHP__DAC4133/DAC4133-main/schematic/xschem/DAC4133_inv.sch
.subckt DAC4133_inv A Y VDD VSS
*.PININFO Y:O A:I VDD:B VSS:B
MMN0 Y A VSS VSS sg13_lv_nmos w=740.00n l=130.00n ng=1
MMP0 Y A VDD VDD sg13_lv_pmos w=1.12u l=130.00n ng=1
.ends
